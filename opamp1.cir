* C:\Users\hp\eSim-Workspace\opamp\opamp1.cir

* EESchema Netlist Version 1.1 (Spice format) creation date: 01/27/24 16:58:17

* To exclude a component from the Spice Netlist add [Spice_Netlist_Enabled] user FIELD set to: N
* To reorder the component spice node sequence add [Spice_Node_Sequence] user FIELD and define sequence: 2,1,0

* Sheet Name: /
X1  ? Net-_R1-Pad2_ GND Net-_X1-Pad4_ ? output Net-_X1-Pad7_ ? lm_741
R1  Input Net-_R1-Pad2_ 1k
Rf1  Net-_R1-Pad2_ output 2k
RL1  GND output 5k
v2  Net-_X1-Pad7_ GND 15
v3  Net-_X1-Pad4_ GND -15
U2  output plot_v2
U1  Input plot_v1
C1  GND Input 1u
C2  output GND 1u
L1  Input output 100m
v1  Input GND sine
L2  Input GND 100m
L3  GND output 100m
C3  output Input 1u

.end
