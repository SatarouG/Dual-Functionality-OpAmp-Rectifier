* C:\Users\hp\eSim-Workspace\opamp\opamp.cir

* EESchema Netlist Version 1.1 (Spice format) creation date: 04/04/24 11:15:08

* To exclude a component from the Spice Netlist add [Spice_Netlist_Enabled] user FIELD set to: N
* To reorder the component spice node sequence add [Spice_Node_Sequence] user FIELD and define sequence: 2,1,0

* Sheet Name: /
X1  ? Net-_R1-Pad2_ Net-_C1-Pad1_ Net-_X1-Pad4_ ? output Net-_X1-Pad7_ ? lm_741
Rf1  Net-_R1-Pad2_ output 0k
RL1  GND output 5k
v2  Net-_X1-Pad7_ GND 15
v3  Net-_X1-Pad4_ GND -15
U2  output plot_v1
U1  Input plot_v1
v1  Input GND sine
C1  Net-_C1-Pad1_ GND 0.01u
D1  Input output eSim_Diode
L1  GND Net-_C1-Pad1_ 10m
R1  Input Net-_R1-Pad2_ 1k

.end
